# Ansys Electronics Desktop project, version 2018.0
materials:
  vacuum: permittivity=1
  Rogers RO4350 (tm): permittivity=3.66 dielectric_loss_tangent=0.004

design HFSSDesign1 (HFSS, DrivenTerminal, model units mm)
variables:
  substrate = 40mm
  h = 31mil
  Lp = 7.5mm
  Wp = 10mm
  x0 = 2.6mm
  y0 = 2.8mm
  w50 = 1.76mm
  L1 = 2mm
  QW = 15mm
geometry:
  Substrate [Rogers RO4350 (tm)] = box(corner=(-substrate/2, -substrate/2, 0mm), size=(substrate, substrate, -h))
  Ground_Plane = rectangle(corner=(-substrate/2, -substrate/2, -h), x_size=substrate, y_size=substrate)
  Patch = rectangle(corner=(-Lp/2, -Wp/2, 0mm), x_size=Lp, y_size=Wp)
  Gap = rectangle(corner=(Lp/2-x0, -y0/2, 0mm), x_size=x0, y_size=y0)
  Patch.subtract(Gap)
  Feed_Line = rectangle(corner=(Lp/2-x0, -w50/2, 0mm), x_size=x0+L1, y_size=w50)
  Patch.unite(Feed_Line)
  source = object_from(Patch.edge(2 of 4))
  source.sweep_along_vector((0mm, 0mm, -h))
  air [vacuum] = box(corner=(-substrate/2, -substrate/2, 0mm), size=(substrate, substrate, QW))
boundaries and excitations:
  PerfE_Ground: Perfect E Objects=Ground_Plane
  PerfE_Patch: Perfect E Objects=Patch
  Radiation: Radiation Faces=air.face(+z, -y, -x, +y, +x)
  Patch_T1: Terminal port=1 Edges=Patch.edge(2 of 4) TerminalResistance=50ohm
  1: Lumped Port Faces=source.face Impedance=50ohm
  reference conductors: Ground_Plane
setups:
  Setup1: HfssDriven Frequency=10GHz MaxDeltaS=0.02 MaximumPasses=15 MinimumPasses=1 MinimumConvergedPasses=1 PercentRefinement=30 BasisOrder=1 PortAccuracy=2
    sweep Sweep: 8GHz to 12GHz, 41 points; Type=Discrete SaveFields
source amplitudes:
  1:1: 1V 0deg
radiation setups:
  Infinite Sphere1: Infinite Sphere Theta=0deg..180deg step 10deg Phi=0deg..360deg step 10deg
reports:
  Terminal S Parameter Plot 1: dB(St(Patch_T1,Patch_T1)) vs Freq on Setup1 : Sweep
  Terminal S Parameter Chart 1: St(Patch_T1,Patch_T1) on Setup1 : Sweep [Freq=all]
  Gain Plot 2: dB(GainTotal) vs Phi, Theta on Setup1 : LastAdaptive, Infinite Sphere1 [Freq=10GHz]
